* Extracted by KLayout with the ICsprout55 LVS runset

.SUBCKT INVX1H7R A VDD|VNW VSS Y
M$1 Y A VSS VSS NM1P2_SVT_LP L=0.06U W=0.21U AS=0.03465P AD=0.03465P PS=0.75U
+ PD=0.75U
M$2 Y A VDD|VNW VDD|VNW PM1P2_SVT_LP L=0.06U W=0.27U AS=0.04455P AD=0.04455P
+ PS=0.87U PD=0.87U
.ENDS INVX1H7R
