* Extracted by KLayout with the ICsprout55 LVS runset

.SUBCKT INVX4H7L A VDD|VNW VSS Y
M$1 Y A VSS VSS NM1P2_LVT_LP L=0.06U W=0.6U AS=0.1056P AD=0.0765P PS=2.24U
+ PD=1.77U
M$5 Y A VDD|VNW VDD|VNW PM1P2_LVT_LP L=0.06U W=0.76U AS=0.09975P AD=0.09975P
+ PS=2U PD=2U
.ENDS INVX4H7L
