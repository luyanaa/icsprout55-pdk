* Extracted by KLayout with the ICsprout55 LVS runset

.SUBCKT TOP MINUS PLUS
XD_$1 PLUS MINUS ics55_ind PARAMS:
.ENDS TOP
