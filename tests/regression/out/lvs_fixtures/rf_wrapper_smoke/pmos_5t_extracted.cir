* Extracted by KLayout with the ICsprout55 LVS runset

.SUBCKT TOP
XD_$1 \$3 \$7 \$2 \$5 \$6 ics55_rf_pmos_svt_5t PARAMS:
.ENDS TOP
