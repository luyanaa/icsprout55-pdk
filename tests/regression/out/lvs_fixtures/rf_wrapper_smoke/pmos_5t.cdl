.SUBCKT TOP D G S B SUB
X1 D G S B SUB ics55_rf_pmos_svt_5t wf=0.5u nf=1 l=0.1u
.ENDS TOP
