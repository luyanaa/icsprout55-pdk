* Extracted by KLayout with the ICsprout55 LVS runset

.SUBCKT TOP
XD_$1 \$2 \$3 \$1 \$4 \$5 \$6 ics55_rf_nmos_svt_6t PARAMS:
.ENDS TOP
