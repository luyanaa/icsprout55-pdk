.SUBCKT TOP D G S
M1 D G S S nm1p2_svt_lp W=0.61u L=0.1u
.ENDS TOP
