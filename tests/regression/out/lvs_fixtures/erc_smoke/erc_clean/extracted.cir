* Extracted by KLayout with the ICsprout55 LVS runset

.SUBCKT TOP IN OUT VDD VSS
M$1 OUT IN VSS VSS NM1P2_SVT_LP L=0.1U W=0.6U AS=0.27P AD=0.27P PS=2.1U PD=2.1U
M$2 VDD IN OUT VDD PM1P2_SVT_LP L=0.1U W=0.6U AS=0.27P AD=0.27P PS=2.1U PD=2.1U
.ENDS TOP
