* Extracted by KLayout with the ICsprout55 LVS runset

* cell TOP
* pin MINUS
* pin PLUS
.SUBCKT TOP MINUS PLUS
.ENDS TOP
