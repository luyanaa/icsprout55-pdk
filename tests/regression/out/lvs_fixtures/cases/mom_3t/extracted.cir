* Extracted by KLayout with the ICsprout55 LVS runset

* cell TOP
* pin B
* pin MINUS
* pin PLUS
.SUBCKT TOP B MINUS PLUS
* device instance $1 r0 *1 -0.9,-1.4 mom_3t
XD_$1 PLUS MINUS B mom_3t PARAMS: LF=1.9 NF=3 BM=2 TM=4 MR=1 SHIELDING=1
.ENDS TOP
