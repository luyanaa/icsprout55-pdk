* Extracted by KLayout with the ICsprout55 LVS runset

* cell TOP
.SUBCKT TOP
.ENDS TOP
