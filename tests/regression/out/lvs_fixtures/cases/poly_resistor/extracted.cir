* Extracted by KLayout with the ICsprout55 LVS runset

* cell TOP
* pin A
* pin B
.SUBCKT TOP A B
* device instance $1 r0 *1 0.5,0.1 RE_PPO_SAB_2T
R$1 A B 3628.5 RE_PPO_SAB_2T
.ENDS TOP
