* Extracted by KLayout with the ICsprout55 LVS runset

* cell TOP
.SUBCKT TOP
* device instance $1 r0 *1 -5.55,-6 ics55_rf_pmos_svt_5t
XD_$1 \$3 \$7 \$2 \$5 \$6 ics55_rf_pmos_svt_5t PARAMS:
.ENDS TOP
