* Extracted by KLayout with the ICsprout55 LVS runset

* cell TOP
* pin MINUS
* pin PLUS
.SUBCKT TOP MINUS|PLUS MINUS|PLUS
* device instance $1 r0 *1 0,0 ics55_ind
XD_$1 MINUS|PLUS MINUS|PLUS ics55_ind PARAMS:
.ENDS TOP
