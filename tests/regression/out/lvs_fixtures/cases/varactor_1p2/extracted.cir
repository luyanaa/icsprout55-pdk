* Extracted by KLayout with the ICsprout55 LVS runset

* cell TOP
.SUBCKT TOP
* device instance $1 r0 *1 -5.55,-6.1 var1p2_npd_nw_lp
XD_$1 \$1 \$2 var1p2_npd_nw_lp PARAMS:
.ENDS TOP
