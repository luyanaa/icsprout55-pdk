* Extracted by KLayout with the ICsprout55 LVS runset

.SUBCKT INVX3H7H A VDD|VNW VSS Y
M$1 Y A VSS VSS NM1P2_HVT_LP L=0.06U W=0.45U AS=0.05625P AD=0.061875P PS=1.175U
+ PD=1.225U
M$3 Y A VDD|VNW VDD|VNW PM1P2_HVT_LP L=0.06U W=0.57U AS=0.0665P AD=0.0684P
+ PS=1.46U PD=1.48U
.ENDS INVX3H7H
