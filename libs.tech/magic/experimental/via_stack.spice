* SPICE3 file created from STACK.ext - technology: ics55

C0 M1_V SUB 1.26076f **FLOATING
C1 m1_300_n100# SUB 0.90124f **FLOATING
C2 P SUB 0.89745f **FLOATING
C3 a_n4_n4# SUB 0.00155f **FLOATING
