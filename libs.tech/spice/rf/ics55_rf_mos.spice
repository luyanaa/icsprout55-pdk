* ICsprout55 RF MOS v0.2: UNCALIBRATED extrinsic 4T/5T/6T structures.
* Requires vendor model .lib tt_mos in the simulation deck; the 5T/6T
* triple-well flavours additionally require .lib tt_dio.
* wf is per-finger drawn width; vendor wrapper w expects TOTAL width.
* Default extrinsic R is tiny to make the baseline nearly identical to
* the vendor BSIM model; C defaults to zero (no fabricated RF coefficients).
* Do not claim signoff-quality fT/fmax/noise without S-parameter correlation.
*
* Pin order:
*   4T : D G S B
*   5T : D G S B DNW      NMOS in DNW, B = P-well
*        D G S B SUB      PMOS in DNW, B = N-well, SUB = p-substrate
*   6T : D G S B DNW PSUB NMOS in DNW with separate p-substrate
* Ported from SMIC55LL_ULP_RF (n12ll_ckt_rf_5t / dnw12ll_ckt_rf_6t /
* p12ll_ckt_rf_5t). SMIC's fitted coefficients are NOT reused.
* The DNW/PW and DNW/PSUB junctions are geometry-scaled estimates.
.subckt ics55_rf_nmos_svt_4t D G S B wf=2u l=60n nf=4
+ sa=0.24u sb=0.24u sd=0.30u mismod=0
+ rg_feed=1u rd_feed=1u rs_feed=1u rb_feed=1u
+ cgd_feed=0 cgs_feed=0 cds_feed=0
Rg G Gi {rg_feed}
Rd D Di {rd_feed}
Rs S Si {rs_feed}
Rb B Bi {rb_feed}
Xcore Di Gi Si Bi nm1p2_svt_lp w={wf*nf} l={l} nf={nf}
+ sa={sa} sb={sb} sd={sd} mismod={mismod} prelayout=0
Cgd Gi Di {cgd_feed}
Cgs Gi Si {cgs_feed}
Cds Di Si {cds_feed}
.ends ics55_rf_nmos_svt_4t

.subckt ics55_rf_pmos_svt_4t D G S B wf=2u l=60n nf=4
+ sa=0.24u sb=0.24u sd=0.30u mismod=0
+ rg_feed=1u rd_feed=1u rs_feed=1u rb_feed=1u
+ cgd_feed=0 cgs_feed=0 cds_feed=0
Rg G Gi {rg_feed}
Rd D Di {rd_feed}
Rs S Si {rs_feed}
Rb B Bi {rb_feed}
Xcore Di Gi Si Bi pm1p2_svt_lp w={wf*nf} l={l} nf={nf}
+ sa={sa} sb={sb} sd={sd} mismod={mismod} prelayout=0
Cgd Gi Di {cgd_feed}
Cgs Gi Si {cgs_feed}
Cds Di Si {cds_feed}
.ends ics55_rf_pmos_svt_4t

.subckt ics55_rf_nmos_lvt_4t D G S B wf=2u l=60n nf=4
+ sa=0.24u sb=0.24u sd=0.30u mismod=0
+ rg_feed=1u rd_feed=1u rs_feed=1u rb_feed=1u
+ cgd_feed=0 cgs_feed=0 cds_feed=0
Rg G Gi {rg_feed}
Rd D Di {rd_feed}
Rs S Si {rs_feed}
Rb B Bi {rb_feed}
Xcore Di Gi Si Bi nm1p2_lvt_lp w={wf*nf} l={l} nf={nf}
+ sa={sa} sb={sb} sd={sd} mismod={mismod} prelayout=0
Cgd Gi Di {cgd_feed}
Cgs Gi Si {cgs_feed}
Cds Di Si {cds_feed}
.ends ics55_rf_nmos_lvt_4t

.subckt ics55_rf_nmos_hvt_4t D G S B wf=2u l=60n nf=4
+ sa=0.24u sb=0.24u sd=0.30u mismod=0
+ rg_feed=1u rd_feed=1u rs_feed=1u rb_feed=1u
+ cgd_feed=0 cgs_feed=0 cds_feed=0
Rg G Gi {rg_feed}
Rd D Di {rd_feed}
Rs S Si {rs_feed}
Rb B Bi {rb_feed}
Xcore Di Gi Si Bi nm1p2_hvt_lp w={wf*nf} l={l} nf={nf}
+ sa={sa} sb={sb} sd={sd} mismod={mismod} prelayout=0
Cgd Gi Di {cgd_feed}
Cgs Gi Si {cgs_feed}
Cds Di Si {cds_feed}
.ends ics55_rf_nmos_hvt_4t

.subckt ics55_rf_pmos_lvt_4t D G S B wf=2u l=60n nf=4
+ sa=0.24u sb=0.24u sd=0.30u mismod=0
+ rg_feed=1u rd_feed=1u rs_feed=1u rb_feed=1u
+ cgd_feed=0 cgs_feed=0 cds_feed=0
Rg G Gi {rg_feed}
Rd D Di {rd_feed}
Rs S Si {rs_feed}
Rb B Bi {rb_feed}
Xcore Di Gi Si Bi pm1p2_lvt_lp w={wf*nf} l={l} nf={nf}
+ sa={sa} sb={sb} sd={sd} mismod={mismod} prelayout=0
Cgd Gi Di {cgd_feed}
Cgs Gi Si {cgs_feed}
Cds Di Si {cds_feed}
.ends ics55_rf_pmos_lvt_4t

.subckt ics55_rf_pmos_hvt_4t D G S B wf=2u l=60n nf=4
+ sa=0.24u sb=0.24u sd=0.30u mismod=0
+ rg_feed=1u rd_feed=1u rs_feed=1u rb_feed=1u
+ cgd_feed=0 cgs_feed=0 cds_feed=0
Rg G Gi {rg_feed}
Rd D Di {rd_feed}
Rs S Si {rs_feed}
Rb B Bi {rb_feed}
Xcore Di Gi Si Bi pm1p2_hvt_lp w={wf*nf} l={l} nf={nf}
+ sa={sa} sb={sb} sd={sd} mismod={mismod} prelayout=0
Cgd Gi Di {cgd_feed}
Cgs Gi Si {cgs_feed}
Cds Di Si {cds_feed}
.ends ics55_rf_pmos_hvt_4t

* ---------------------------------------------------------------------------
* 5T/6T triple-well flavours. The core is the matching 4T subcircuit; only
* the well/substrate junction network is added. pw_dnw_enc / dnw_psub_enc
* are the active-to-DNW and DNW-to-PSUB enclosure estimates used to size the
* reverse-biased junctions.
* ---------------------------------------------------------------------------

.subckt ics55_rf_nmos_svt_5t D G S B DNW wf=2u l=60n nf=4
+ sa=0.24u sb=0.24u sd=0.30u mismod=0
+ rg_feed=1u rd_feed=1u rs_feed=1u rb_feed=1u
+ cgd_feed=0 cgs_feed=0 cds_feed=0
+ rwell=1k pw_dnw_enc=0.5u
.param apw='(wf*nf+2*pw_dnw_enc)*(l+2*pw_dnw_enc)'
.param ppw='2*((wf*nf+2*pw_dnw_enc)+(l+2*pw_dnw_enc))'
Xm D G S B ics55_rf_nmos_svt_4t wf={wf} l={l} nf={nf}
+ sa={sa} sb={sb} sd={sd} mismod={mismod}
+ rg_feed={rg_feed} rd_feed={rd_feed} rs_feed={rs_feed} rb_feed={rb_feed}
+ cgd_feed={cgd_feed} cgs_feed={cgs_feed} cds_feed={cds_feed}
Rwell B DNW {rwell}
Dbd B DNW dio_1p2_pw_dnw_lp AREA={apw} PJ={ppw}
.ends ics55_rf_nmos_svt_5t

.subckt ics55_rf_nmos_lvt_5t D G S B DNW wf=2u l=60n nf=4
+ sa=0.24u sb=0.24u sd=0.30u mismod=0
+ rg_feed=1u rd_feed=1u rs_feed=1u rb_feed=1u
+ cgd_feed=0 cgs_feed=0 cds_feed=0
+ rwell=1k pw_dnw_enc=0.5u
.param apw='(wf*nf+2*pw_dnw_enc)*(l+2*pw_dnw_enc)'
.param ppw='2*((wf*nf+2*pw_dnw_enc)+(l+2*pw_dnw_enc))'
Xm D G S B ics55_rf_nmos_lvt_4t wf={wf} l={l} nf={nf}
+ sa={sa} sb={sb} sd={sd} mismod={mismod}
+ rg_feed={rg_feed} rd_feed={rd_feed} rs_feed={rs_feed} rb_feed={rb_feed}
+ cgd_feed={cgd_feed} cgs_feed={cgs_feed} cds_feed={cds_feed}
Rwell B DNW {rwell}
Dbd B DNW dio_1p2_pw_dnw_lp AREA={apw} PJ={ppw}
.ends ics55_rf_nmos_lvt_5t

.subckt ics55_rf_nmos_hvt_5t D G S B DNW wf=2u l=60n nf=4
+ sa=0.24u sb=0.24u sd=0.30u mismod=0
+ rg_feed=1u rd_feed=1u rs_feed=1u rb_feed=1u
+ cgd_feed=0 cgs_feed=0 cds_feed=0
+ rwell=1k pw_dnw_enc=0.5u
.param apw='(wf*nf+2*pw_dnw_enc)*(l+2*pw_dnw_enc)'
.param ppw='2*((wf*nf+2*pw_dnw_enc)+(l+2*pw_dnw_enc))'
Xm D G S B ics55_rf_nmos_hvt_4t wf={wf} l={l} nf={nf}
+ sa={sa} sb={sb} sd={sd} mismod={mismod}
+ rg_feed={rg_feed} rd_feed={rd_feed} rs_feed={rs_feed} rb_feed={rb_feed}
+ cgd_feed={cgd_feed} cgs_feed={cgs_feed} cds_feed={cds_feed}
Rwell B DNW {rwell}
Dbd B DNW dio_1p2_pw_dnw_lp AREA={apw} PJ={ppw}
.ends ics55_rf_nmos_hvt_5t

.subckt ics55_rf_nmos_svt_6t D G S B DNW PSUB wf=2u l=60n nf=4
+ sa=0.24u sb=0.24u sd=0.30u mismod=0
+ rg_feed=1u rd_feed=1u rs_feed=1u rb_feed=1u
+ cgd_feed=0 cgs_feed=0 cds_feed=0
+ rwell=1k pw_dnw_enc=0.5u dnw_psub_enc=2u
.param apw='(wf*nf+2*pw_dnw_enc)*(l+2*pw_dnw_enc)'
.param ppw='2*((wf*nf+2*pw_dnw_enc)+(l+2*pw_dnw_enc))'
.param adnw='(wf*nf+2*dnw_psub_enc)*(l+2*dnw_psub_enc)'
.param pdnw='2*((wf*nf+2*dnw_psub_enc)+(l+2*dnw_psub_enc))'
Xm D G S B ics55_rf_nmos_svt_4t wf={wf} l={l} nf={nf}
+ sa={sa} sb={sb} sd={sd} mismod={mismod}
+ rg_feed={rg_feed} rd_feed={rd_feed} rs_feed={rs_feed} rb_feed={rb_feed}
+ cgd_feed={cgd_feed} cgs_feed={cgs_feed} cds_feed={cds_feed}
Rwell B DNW {rwell}
Dbd B DNW dio_1p2_pw_dnw_lp AREA={apw} PJ={ppw}
Dpsub PSUB DNW dio_1p2_dnw_psub_lp AREA={adnw} PJ={pdnw}
.ends ics55_rf_nmos_svt_6t

.subckt ics55_rf_nmos_lvt_6t D G S B DNW PSUB wf=2u l=60n nf=4
+ sa=0.24u sb=0.24u sd=0.30u mismod=0
+ rg_feed=1u rd_feed=1u rs_feed=1u rb_feed=1u
+ cgd_feed=0 cgs_feed=0 cds_feed=0
+ rwell=1k pw_dnw_enc=0.5u dnw_psub_enc=2u
.param apw='(wf*nf+2*pw_dnw_enc)*(l+2*pw_dnw_enc)'
.param ppw='2*((wf*nf+2*pw_dnw_enc)+(l+2*pw_dnw_enc))'
.param adnw='(wf*nf+2*dnw_psub_enc)*(l+2*dnw_psub_enc)'
.param pdnw='2*((wf*nf+2*dnw_psub_enc)+(l+2*dnw_psub_enc))'
Xm D G S B ics55_rf_nmos_lvt_4t wf={wf} l={l} nf={nf}
+ sa={sa} sb={sb} sd={sd} mismod={mismod}
+ rg_feed={rg_feed} rd_feed={rd_feed} rs_feed={rs_feed} rb_feed={rb_feed}
+ cgd_feed={cgd_feed} cgs_feed={cgs_feed} cds_feed={cds_feed}
Rwell B DNW {rwell}
Dbd B DNW dio_1p2_pw_dnw_lp AREA={apw} PJ={ppw}
Dpsub PSUB DNW dio_1p2_dnw_psub_lp AREA={adnw} PJ={pdnw}
.ends ics55_rf_nmos_lvt_6t

.subckt ics55_rf_nmos_hvt_6t D G S B DNW PSUB wf=2u l=60n nf=4
+ sa=0.24u sb=0.24u sd=0.30u mismod=0
+ rg_feed=1u rd_feed=1u rs_feed=1u rb_feed=1u
+ cgd_feed=0 cgs_feed=0 cds_feed=0
+ rwell=1k pw_dnw_enc=0.5u dnw_psub_enc=2u
.param apw='(wf*nf+2*pw_dnw_enc)*(l+2*pw_dnw_enc)'
.param ppw='2*((wf*nf+2*pw_dnw_enc)+(l+2*pw_dnw_enc))'
.param adnw='(wf*nf+2*dnw_psub_enc)*(l+2*dnw_psub_enc)'
.param pdnw='2*((wf*nf+2*dnw_psub_enc)+(l+2*dnw_psub_enc))'
Xm D G S B ics55_rf_nmos_hvt_4t wf={wf} l={l} nf={nf}
+ sa={sa} sb={sb} sd={sd} mismod={mismod}
+ rg_feed={rg_feed} rd_feed={rd_feed} rs_feed={rs_feed} rb_feed={rb_feed}
+ cgd_feed={cgd_feed} cgs_feed={cgs_feed} cds_feed={cds_feed}
Rwell B DNW {rwell}
Dbd B DNW dio_1p2_pw_dnw_lp AREA={apw} PJ={ppw}
Dpsub PSUB DNW dio_1p2_dnw_psub_lp AREA={adnw} PJ={pdnw}
.ends ics55_rf_nmos_hvt_6t

.subckt ics55_rf_pmos_svt_5t D G S B SUB wf=2u l=60n nf=4
+ sa=0.24u sb=0.24u sd=0.30u mismod=0
+ rg_feed=1u rd_feed=1u rs_feed=1u rb_feed=1u
+ cgd_feed=0 cgs_feed=0 cds_feed=0
+ rwell=1k nw_psub_enc=0.5u
.param anw='(wf*nf+2*nw_psub_enc)*(l+2*nw_psub_enc)'
.param pnw='2*((wf*nf+2*nw_psub_enc)+(l+2*nw_psub_enc))'
Xm D G S B ics55_rf_pmos_svt_4t wf={wf} l={l} nf={nf}
+ sa={sa} sb={sb} sd={sd} mismod={mismod}
+ rg_feed={rg_feed} rd_feed={rd_feed} rs_feed={rs_feed} rb_feed={rb_feed}
+ cgd_feed={cgd_feed} cgs_feed={cgs_feed} cds_feed={cds_feed}
Rwell B SUB {rwell}
Dnw SUB B dio_1p2_nw_psub_lp AREA={anw} PJ={pnw}
.ends ics55_rf_pmos_svt_5t

.subckt ics55_rf_pmos_lvt_5t D G S B SUB wf=2u l=60n nf=4
+ sa=0.24u sb=0.24u sd=0.30u mismod=0
+ rg_feed=1u rd_feed=1u rs_feed=1u rb_feed=1u
+ cgd_feed=0 cgs_feed=0 cds_feed=0
+ rwell=1k nw_psub_enc=0.5u
.param anw='(wf*nf+2*nw_psub_enc)*(l+2*nw_psub_enc)'
.param pnw='2*((wf*nf+2*nw_psub_enc)+(l+2*nw_psub_enc))'
Xm D G S B ics55_rf_pmos_lvt_4t wf={wf} l={l} nf={nf}
+ sa={sa} sb={sb} sd={sd} mismod={mismod}
+ rg_feed={rg_feed} rd_feed={rd_feed} rs_feed={rs_feed} rb_feed={rb_feed}
+ cgd_feed={cgd_feed} cgs_feed={cgs_feed} cds_feed={cds_feed}
Rwell B SUB {rwell}
Dnw SUB B dio_1p2_nw_psub_lp AREA={anw} PJ={pnw}
.ends ics55_rf_pmos_lvt_5t

.subckt ics55_rf_pmos_hvt_5t D G S B SUB wf=2u l=60n nf=4
+ sa=0.24u sb=0.24u sd=0.30u mismod=0
+ rg_feed=1u rd_feed=1u rs_feed=1u rb_feed=1u
+ cgd_feed=0 cgs_feed=0 cds_feed=0
+ rwell=1k nw_psub_enc=0.5u
.param anw='(wf*nf+2*nw_psub_enc)*(l+2*nw_psub_enc)'
.param pnw='2*((wf*nf+2*nw_psub_enc)+(l+2*nw_psub_enc))'
Xm D G S B ics55_rf_pmos_hvt_4t wf={wf} l={l} nf={nf}
+ sa={sa} sb={sb} sd={sd} mismod={mismod}
+ rg_feed={rg_feed} rd_feed={rd_feed} rs_feed={rs_feed} rb_feed={rb_feed}
+ cgd_feed={cgd_feed} cgs_feed={cgs_feed} cds_feed={cds_feed}
Rwell B SUB {rwell}
Dnw SUB B dio_1p2_nw_psub_lp AREA={anw} PJ={pnw}
.ends ics55_rf_pmos_hvt_5t
